;(load "~/git/sfq-adptools/source/debug/reload.ils")
(define reloadADPTOOLS nil)
(let ()
 (define option nil)
 (defun createOption ()
  (define file (getPathADPToolsSource))
  (setq file (sprintf nil "%s/load.ils" file))
  (unless option
          (setq option
                (hiCreateAppForm
                 ?name
                 (gensym 'option)
                 ?fields
                 (list
                  (hiCreateStringField
                   ?name
                   'path
                   ?prompt
                   "path to load.ils"
                   ?defValue
                   file)))))
  (hiDisplayForm option))

 reloadADPTOOLS
 =
 (lambda ()
  (when (createOption)
        (inSkill
         ADPSchematicMenu = 'unbound
         ADPLayoutMenu = 'unbound)
        (deUnRegUserTriggers "schematic")
        (deUnRegUserTriggers "maskLayout")
        (deUnRegUserTriggers "maskLayoutXL")
        (load option->path->value))))

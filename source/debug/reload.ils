;(load "~/git/sfq-adptools/source/debug/reload.ils")
(inSkill
  ADPSchematicMenu='unbound
  ADPLayoutMenu='unbound
  )

(deUnRegUserTriggers "schematic")
;(deUnRegUserTriggers "maskLayout")
(deUnRegUserTriggers "maskLayoutXL")

(let ()
  (define pathAndFile nil)
  (define path #.get_filename(piport))
  (setq path (parseString path "/"))
  (remd (car (last path)) path)
  (remd (car (last path)) path)
  (setq path (buildString path "/"))
  (define file "load.ils")
  (when (isReadable (setq pathAndFile (buildString (list path file) "/" )))
    (load pathAndFile)))

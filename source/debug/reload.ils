;(load "~/git/sfq-adptools/source/debug/reload.ils")
(inSkill
  ADPSchematicMenu='unbound
  ADPLayoutMenu='unbound
  )

(deUnRegUserTriggers "schematic")
(deUnRegUserTriggers "maskLayout")
(deUnRegUserTriggers "maskLayoutXL")

(let ()
  (define file (getPathADPToolsSource ))
  (setq file (sprintf nil "%s/load.ils" file))
  (when (isReadable file)
    (load file))
  )

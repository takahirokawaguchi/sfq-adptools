;(load "~/git/adptools/source/functions/menu.ils")
(define createSFQADPMenu nil)
(let ()
  (defun gensymSFQADPMenuItem ()
    (gensym 'SFQADPMenuItem))

  (defun simpleCreateMenuItem (itemText callback)
    (hiCreateMenuItem
      ?name (gensymSFQADPMenuItem )
      ?itemText itemText
      ?callback callback))

  (defun makeSlider1 ()
    (hiCreateSliderMenuItem
      ?name (gensymSFQADPMenuItem )
      ?itemText "router"
      ?subMenu
      (hiCreatePulldownMenu
        (gensymSFQADPMenuItem )
        ""
        (list
          (simpleCreateMenuItem
            "placeOnGrid"
            "(roAdjustAllInsts (geGetWindowCellView ))")
          (simpleCreateMenuItem
            "routeAll"
            "(rRoute (geGetWindowCellView ) \"all\")")
          (simpleCreateMenuItem
            "routeSelected"
            "(rRoute (geGetWindowCellView ) \"selected\")")
          (simpleCreateMenuItem
            "selected nets -> ptl nets"
            "(makePtlWire )")
          (simpleCreateMenuItem
            "all ptl nets -> nets"
            "(undoPTLWire (geGetWindowCellView ))")
          (simpleCreateMenuItem
            "all ptl cells -> ptl nets"
            "(undoPTLCellAll ) ")
          (simpleCreateMenuItem
            "selected ptl cells -> ptl nets"
            "(undoPTLCellSelected ) ")
          (simpleCreateMenuItem
            "all ptl nets -> ptl cells"
            "(rNet2ptl \"all\") ")
          (simpleCreateMenuItem
            "selected ptl nets -> ptl cells"
            "(rNet2ptl \"selected\" )"))
        )))

  (defun makeSlider2 ()
    (hiCreateSliderMenuItem
      ?name (gensymSFQADPMenuItem )
      ?itemText "debug"
      ?subMenu
      (hiCreatePulldownMenu
        (gensymSFQADPMenuItem )
        ""
        (list
          (simpleCreateMenuItem
            "mloadMySkill"
            (strcat "(mload \"~/git/route/source\") "
                    "(mload \"~/git/dat/source\") "
                    "(mload \"~/git/placement/source\") "
                    "(mload \"~/git/skill\")"))
          (simpleCreateMenuItem
            "setqScvGeGetWindowCellView"
            "(setq scv (geGetWindowCellView ))")
          (simpleCreateMenuItem
            "scvCellNames"
            "(scvCellNames (geGetWindowCellView ))")
          (simpleCreateMenuItem
            "setqSelGeGetSelSet"
            "(setq sel (geGetSelSet ))")
          (simpleCreateMenuItem
            "deleteNormalLabel"
            "(deleteNormalLabel )"))
        )))

  (defun letCreateSFQADPMenu (args)
    ;main menu
    (unless (boundp 'SFQADPMenu)
      (hiCreatePulldownMenu
        'SFQADPMenu
        "SFQ-ADP"
        (list
          (makeSlider1 )
          (hiCreateSeparatorMenuItem ?name (gensymSFQADPMenuItem ))
          (simpleCreateMenuItem
            "fillMoatADP"
            "(fillMoatADP (geGetWindowCellView ) nil)")
          (simpleCreateMenuItem
            "displayArrivalTime"
            "(datGui )")
          (simpleCreateMenuItem
            "logicExtraction"
            "(c2vFront )")
          (simpleCreateMenuItem
            "cell(s) translater"
            "(guiTranslateCell )")
          (hiCreateSeparatorMenuItem ?name (gensymSFQADPMenuItem ))
          (makeSlider2 )
          )))
    (list 'SFQADPMenu))
  createSFQADPMenu = letCreateSFQADPMenu
  );let

(deRegUserTriggers
  "schematic"
  nil
  'createSFQADPMenu)

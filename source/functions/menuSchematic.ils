;(load "~/git/adptools/source/functions/menu.ils")
(define createADPSchematicMenu nil)
(let ()
  (defun gensymADPSchematicMenuItem ()
    (gensym 'ADPSchematicMenuItem))

  (defun simpleCreateMenuItem (itemText callback)
    (hiCreateMenuItem
      ?name (gensymADPSchematicMenuItem )
      ?itemText itemText
      ?callback callback))

  (defun makeSlider1 ()
    (hiCreateSliderMenuItem
      ?name (gensymADPSchematicMenuItem )
      ?itemText "router"
      ?subMenu
      (hiCreatePulldownMenu
        (gensymADPSchematicMenuItem )
        ""
        (list
          (simpleCreateMenuItem
            "placeOnGrid"
            "(roAdjustAllInsts (geGetWindowCellView ))")
          (simpleCreateMenuItem
            "routeAll"
            "(rRoute (geGetWindowCellView ) \"all\")")
          (simpleCreateMenuItem
            "routeSelected"
            "(rRoute (geGetWindowCellView ) \"selected\")")
          (simpleCreateMenuItem
            "selected nets -> ptl nets"
            "(makePtlWire )")
          (simpleCreateMenuItem
            "all ptl nets -> nets"
            "(undoPTLWire (geGetWindowCellView ))")
          (simpleCreateMenuItem
            "all ptl cells -> ptl nets"
            "(undoPTLCellAll ) ")
          (simpleCreateMenuItem
            "selected ptl cells -> ptl nets"
            "(undoPTLCellSelected ) ")
          (simpleCreateMenuItem
            "all ptl nets -> ptl cells"
            "(rNet2ptl \"all\") ")
          (simpleCreateMenuItem
            "selected ptl nets -> ptl cells"
            "(rNet2ptl \"selected\" )"))
        )))

  (defun makeSlider2 ()
    (hiCreateSliderMenuItem
      ?name (gensymADPSchematicMenuItem )
      ?itemText "debug"
      ?subMenu
      (hiCreatePulldownMenu
        (gensymADPSchematicMenuItem )
        ""
        (list
          (simpleCreateMenuItem
            "(load \"~/git/adptools/source/debug/reload.ils\")"
            "(load \"~/git/adptools/source/debug/reload.ils\")")
          (simpleCreateMenuItem
            "(setq scv (geGetWindowCellView ))"
            "(setq scv (geGetWindowCellView ))")
          (simpleCreateMenuItem
            "scvCellNames"
            "(scvCellNames (geGetWindowCellView ))")
          (simpleCreateMenuItem
            "(setq sel (geGetSelSet ))"
            "(setq sel (geGetSelSet ))")
          (simpleCreateMenuItem
            "deleteNormalLabel"
            "(deleteNormalLabel )"))
        )))

  (defun letCreateADPSchematicMenu (args)
    ;main menu
    (unless (boundp 'ADPSchematicMenu)
      (hiCreatePulldownMenu
        'ADPSchematicMenu
        "SFQ-ADP"
        (list
          (makeSlider1 )
          (hiCreateSeparatorMenuItem ?name (gensymADPSchematicMenuItem ))
          (simpleCreateMenuItem
            "fillMoatADP"
            "(fillMoatADP (geGetWindowCellView ) nil)")
          (simpleCreateMenuItem
            "displayArrivalTime"
            "(datGui )")
          (simpleCreateMenuItem
            "logicExtraction"
            "(c2vFront )")
          (simpleCreateMenuItem
            "cell(s) translater"
            "(guiTranslateCell )")
          (hiCreateSeparatorMenuItem ?name (gensymADPSchematicMenuItem ))
          (makeSlider2 )
          )))
    (list 'ADPSchematicMenu))
  createADPSchematicMenu = letCreateADPSchematicMenu
  );let

(deRegUserTriggers
  "schematic"
  nil
  'createADPSchematicMenu)

(define placeAllContacts nil)
(let ()
  (define option nil)
  (defun createOption ()
    (unless option
      (setq option
            (hiCreateAppForm
              ?name (gensym 'option)
              ?fields
              (list
                (hiCreateStringField
                  ?name 'libName
                  ?prompt
                  "library name"
                  ?defValue
                  "ptl_layout")
                (hiCreateStringField
                  ?name 'GCPTL1
                  ?prompt
                  "name of ground contact for PTL1"
                  ?defValue
                  "GCPTL1")
                (hiCreateStringField
                  ?name 'GCPTL2
                  ?prompt
                  "name of ground contact for PTL2"
                  ?defValue
                  "GCPTL2")
                (hiCreateStringField
                  ?name 'GCPTL2DRVREC
                  ?prompt
                  "name of ground contact for PTL DRV/REC"
                  ?defValue
                  "GCPTL2DRVREC")
                ))))
    (hiDisplayForm option)
    )

  (define cv nil)
  (define lib nil)
  placeAllContacts =
  (lambda ()
    (setq cv (geGetWindowCellView ))
    (when (createOption )
    (setq lib option->libName->value))
    (printf "%L\n" lib)
    (printf "%L\n" option->GCPTL1->name)
    (define layer nil)
    (foreach
      net cv~>nets
      (foreach
        fig (setof x net~>figs (equal x~>objType "line"))
        (placeContact fig (mapcar 'getInstTermCoord net~>instTerms)))
      ))

  (defun placeContact (fig psInstTerm)
    (define points nil)
    (setq
      pairsPoints
      (list
        (list
          (car fig~>points)
          (cadr fig~>points))
        (list
          (car (last fig~>points))
          (nth (plus -2 (length fig~>points)) fig~>points)
          )))
    (foreach
      pairP pairsPoints
      (dbCreateInst
        cv
        (cond
          ((member (car pairP) psInstTerm)
           (dbOpenCellViewByType
             lib
             option->GCPTL2DRVREC->value
             "layout"))
          ((equal fig~>layerName "PTL2")
           (dbOpenCellViewByType
             lib
             option->GCPTL2->value
             "layout"))
          ((equal fig~>layerName "PTL1")
           (dbOpenCellViewByType
             lib
             option->GCPTL1->value
             "layout")))
        nil
        (car pairP)
        (calculateOrientContact pairP)
        )))

  (defun calculateOrientContact (ps)
    (cond ((equal (xCoord (car ps))
                  (xCoord (cadr ps)))
           (if (lessp (yCoord (car ps))
                      (yCoord (cadr ps)))
             "R90"
             "R270"
             ))
          ((equal (yCoord (car ps))
                  (yCoord (cadr ps)))
           (if (lessp (xCoord (car ps))
                      (xCoord (cadr ps)))
             "R0"
             "R180"
             ))
          (t nil)))
  )

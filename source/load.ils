;(load "~/git/adptools/source/load.ils")
(let ()
  (defun loadIlsSFQADP (dirPath)
    (let (files)
      (setq files (setof file (getDirFiles dirPath) (rexMatchp ".ils$" file)))
      (foreach file files
               (printf "[INFO] loading %s\n" file)
               (loadi (buildString (list dirPath file) "/"))
               )))

  (define loadDirs
    (list
      "functions"
      "timing"
      "route"
      "layout"
      ))
  (define pathAndDir nil)
  (define path #.get_filename(piport))
  (setq path (parseString path "/"))
  (remd (car (last path)) path)
  (setq path (buildString path "/"))
  (foreach
    dir loadDirs
    (when (isReadable (setq pathAndDir (buildString (list path dir) "/" )))
      (loadIlsSFQADP pathAndDir))))

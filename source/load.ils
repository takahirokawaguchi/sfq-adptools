;(load "~/git/sfq-adptools/source/load.ils")
(defun getPathADPToolsSource ()
  (define pathToThisFile #.get_filename(piport))
  (define path (parseString pathToThisFile "/"))
  (remd (car (last path)) path)
  (buildString path "/"))

(let ()
  (defun loadIlsSFQADP (dirPath)
    (let (files)
      (setq files (setof file (getDirFiles dirPath) (rexMatchp ".ils$" file)))
      (foreach file files
               (printf "[INFO] loading %s\n" file)
               (loadi (buildString (list dirPath file) "/"))
               )))

  (define loadDirs
    (list
      "functions"
      "menu"
      "route"
      "timing"
      "layout"
      ))

  (define path (getPathADPToolsSource ))
  (printf "[INFO] loading %s/load.ils\n" path)
  (define pathAndDir nil)
  (foreach
    dir loadDirs
    (when (isReadable (setq pathAndDir (buildString (list path dir) "/" )))
      (printf "[INFO] loading the directory: %s\n" pathAndDir)
      (loadIlsSFQADP pathAndDir))))

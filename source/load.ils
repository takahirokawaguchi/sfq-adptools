;(load "~/git/sfq-adptools/source/load.ils")
(defun getPathADPToolsSource ()
  (define pathToThisFile #.get_filename(piport))
  (define path (parseString pathToThisFile "/"))
  (remd (car (last path)) path)
  (buildString path "/")
  )

(let ()
  (defun loadIlsSFQADP (dirPath)
    (let (files)
      (setq files (setof file (getDirFiles dirPath) (rexMatchp ".ils$" file)))
      (foreach file files
               (printf "[FILE] loading %s\n" file)
               (loadi (buildString (list dirPath file) "/"))
               )))

  (define loadDirs
    (list
      "debug"
      "functions"
      "menu"
      "route"
      "timing"
      "layout"
      ))

  (define path (getPathADPToolsSource ))
  (printf "[LOAD] loading %s/load.ils\n" path)
  (define pathAndDir nil)
  (foreach
    dir loadDirs
    (setq pathAndDir (buildString (list path dir) "/" ))
    (printf "[DEBUG] %s\n" pathAndDir)
    (when (isReadable pathAndDir)
      (printf "[DIR] loading %s\n" pathAndDir)
      (loadIlsSFQADP pathAndDir)
      )))

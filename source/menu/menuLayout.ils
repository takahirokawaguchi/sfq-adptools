(defun createADPLayoutMenu  (args)
  (unless (boundp 'ADPLayoutMenu)
    (hiCreatePulldownMenu
      'ADPLayoutMenu
      "SFQ-ADP"
      (list
        ;(simpleCreateMenuItem
        ;  "deleteAllPathSegs"
        ;  "(deleteAllPathSegs )")
        ;(simpleCreateMenuItem
        ;  "deleteAllTrls"
        ;  "(deleteAllTrls )")
        ;(simpleCreateMenuItem
        ;  "deleteAllVias"
        ;  "(deleteAllVias )")
        (simpleCreateMenuItem
          "place cells according to schematic"
          "(placeCellsFromSToL )")
        (simpleCreateMenuItem
          "copy nets according to schematic"
          "(routeFromSToL )")
        (simpleCreateMenuItem
          "convert pathSeg to Trl"
          "(replacePathSegToTrl )")
        (simpleCreateMenuItem
          "place contacts"
          "(placeAllContacts )")
        (hiCreateSeparatorMenuItem ?name (gensymMenuItem ))
        (simpleCreateMenuItem
          "delete PTL wires, ground contacts, or vias"
          "(deleteLayoutComponent )")
        (hiCreateSeparatorMenuItem ?name (gensymMenuItem ))
        (simpleCreateMenuItem
          "(load \"~/git/sfq-adptools/source/debug/reload.ils\")"
          "(load \"~/git/sfq-adptools/source/debug/reload.ils\")")
        (simpleCreateMenuItem
          "(setq sel (geGetSelSet ))"
          "(setq sel (geGetSelSet ))")
        (simpleCreateMenuItem
          "(setq cv (geGetWindowCellView ))"
          "(setq cv (geGetWindowCellView ))")
        )))
  (list 'ADPLayoutMenu))

(deRegUserTriggers
  "maskLayout"
  nil
  'createADPLayoutMenu)

(deRegUserTriggers
  "maskLayoutXL"
  nil
  'createADPLayoutMenu)

;(load "~/git/adptools/source/functions/menu.ils")
(define createADPSchematicMenu nil)
;(let ()
  (defun gensymADPSchematicMenuItem ()
    (gensym 'ADPSchematicMenuItem))

  (defun simpleCreateMenuItem (itemText callback)
    (hiCreateMenuItem
      ?name (gensymADPSchematicMenuItem )
      ?itemText itemText
      ?callback callback))

;  (defun makeSlider1 ()
;    (hiCreateSliderMenuItem
;      ?name (gensymADPSchematicMenuItem )
;      ?itemText "router"
;      ?subMenu
;      (hiCreatePulldownMenu
;        (gensymADPSchematicMenuItem )
;        ""
;        (list
;          (simpleCreateMenuItem
;            "placeOnGrid"
;            "(roAdjustAllInsts (geGetWindowCellView ))")
;          (simpleCreateMenuItem
;            "route all nets"
;            "(rRoute \"all\")")
;          (simpleCreateMenuItem
;            "route selected nets"
;            "(rRoute \"selected\")")
;          (simpleCreateMenuItem
;            "translate ptl"
;            "(guiPTLTranslater )")
;          ))))

  (defun makeSlider ()
    (hiCreateSliderMenuItem
      ?name (gensymADPSchematicMenuItem )
      ?itemText "debug"
      ?subMenu
      (hiCreatePulldownMenu
        (gensymADPSchematicMenuItem )
        ""
        (list
          (simpleCreateMenuItem
            "(load \"~/git/sfq-adptools/source/debug/reload.ils\")"
            "(load \"~/git/sfq-adptools/source/debug/reload.ils\")")
          (simpleCreateMenuItem
            "(setq scv (geGetWindowCellView ))"
            "(setq scv (geGetWindowCellView ))")
          (simpleCreateMenuItem
            "(setq sel (geGetSelSet ))"
            "(setq sel (geGetSelSet ))")
          (simpleCreateMenuItem
            "scvCellNames"
            "(scvCellNames (geGetWindowCellView ))")
          (simpleCreateMenuItem
            "deleteNormalLabel"
            "(deleteNormalLabel )"))
        )))

  createADPSchematicMenu =
  (lambda (args)
    ;main menu
    (println "debug")
    (unless (boundp 'ADPSchematicMenu)
    (println "unless boundp ADPSchematicMenu")
      (hiCreatePulldownMenu
        'ADPSchematicMenu
        "SFQ-ADP"
        (list
          (simpleCreateMenuItem
            "adjust placement to route"
            "(roAdjustAllInsts (geGetWindowCellView ))")
          (simpleCreateMenuItem
            "route all nets"
            "(rRoute \"all\")")
          (simpleCreateMenuItem
            "route selected nets"
            "(rRoute \"selected\")")
          (simpleCreateMenuItem
            "translate ptl"
            "(guiPTLTranslater )")
          (hiCreateSeparatorMenuItem ?name (gensymADPSchematicMenuItem ))
          (simpleCreateMenuItem
            "replace drvPTL2 recPTL2 and pspl2 with those without ground contacts"
            "(replaceDrvRec )")
          (hiCreateSeparatorMenuItem ?name (gensymADPSchematicMenuItem ))
          (simpleCreateMenuItem
            "fillMoatADP"
            "(fillMoatADP (geGetWindowCellView ) nil)")
          (simpleCreateMenuItem
            "displayArrivalTime"
            "(datGui )")
          (simpleCreateMenuItem
            "logicExtraction"
            "(c2vFront )")
          (simpleCreateMenuItem
            "cell(s) translater"
            "(guiTranslateCell )")
          (hiCreateSeparatorMenuItem ?name (gensymADPSchematicMenuItem ))
          (makeSlider )
          )))
    (list 'ADPSchematicMenu))
;  );let

(deRegUserTriggers
  "schematic"
  nil
  'createADPSchematicMenu)

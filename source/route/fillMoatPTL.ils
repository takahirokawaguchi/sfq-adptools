(defun fillMoatADP (cellViewId libName)
  (define cellbBox nil)
  (define masterCellViewId nil)
  (define llX nil)
  (define llY nil)
  (define urX nil)
  (define urY nil)
  (define lenX nil)
  (define lenY nil)
  (define moatArray nil)
  (define cellSize nil)
  (define xCell nil)
  (define yCell nil)
  (define corners nil)
  (define llxCell nil)
  (define llyCell nil)
  (define urxCell nil)
  (define uryCell nil)
  (define x nil)
  (define y nil)
  (define ignoreLibs '("analogJJ" "basic" ))
  (define ignoreCells '("sfqdc*" "dcsfq*" "ipin" "opin" "^PTL*" "via*" ))
  (define SFQLayoutSymbolUnitLength 0.375)
  (unless libName
    (setq libName
          guessRefLibId( cellViewId )~>name))
  ; check if the moat cell exists
  (if (setq masterCellViewId
            (dbOpenCellViewByType
              ;guessRefLibId( cellViewId )~>name
              libName
              "moat"
              "symbol_p"
              nil
              "r"))
    then
    ; calculate the number of cells in x and y-axis
    (setq cellbBox (getCellViewbBoxADP cellViewId SFQLayoutSymbolUnitLength ignoreLibs ignoreCells))
    (setq llX (xCoord (lowerLeft cellbBox)))
    (setq llY (yCoord (lowerLeft cellbBox)))
    (setq urX (xCoord (upperRight cellbBox)))
    (setq urY (yCoord (upperRight cellbBox)))
    (setq lenX (floor (urX - llX) / SFQLayoutSymbolUnitLength ))
    (setq lenY (floor (urY - llY) / SFQLayoutSymbolUnitLength ))
    ; declare 2D array for moat filling
    (setq moatArray (makeMoatArray lenX lenY))
    (for
      indexY 0 lenY-1
      (for
        indexX 0 lenX-1
        moatArray[indexX][indexY] = t))
    ; set moatArray t if a cell exists
    (foreach
      inst cellViewId~>instances
      (unless
        (or (member inst~>libName ignoreLibs)
             ;!member( t foreach( mapcar cell ignoreCells
             ;                           rexMatchp( cell inst~>cellName ) ) )
             (exists x ignoreCells (rexMatchp x inst~>cellName)))
        ; calculate the lower-left and upper-right coordinates of the instance
        (setq cellbBox (getCellbBoxADP inst SFQLayoutSymbolUnitLength))
        (setq llxCell (xCoord (lowerLeft cellbBox)))
        (setq llyCell (yCoord (lowerLeft cellbBox)))
        (setq urxCell (xCoord (upperRight cellbBox)))
        (setq uryCell (yCoord (upperRight cellbBox)))
        ; set moatArray t in accordnace with the cell coordinates
        (for
          indexY
          (floor ( llyCell - llY )/SFQLayoutSymbolUnitLength )
          (floor ( uryCell - llY )/SFQLayoutSymbolUnitLength ) - 1
          (for
            indexX
            (floor ( llxCell - llX )/SFQLayoutSymbolUnitLength )
            (floor ( urxCell - llX )/SFQLayoutSymbolUnitLength ) - 1
            moatArray[indexX][indexY]=nil
            ))))
    ; read moatArray and place a moat if moatArray==t
    (for indexY 0 lenY-1
      (for indexX 0 lenX-1
        (when moatArray[indexX][indexY]
          (dbCreateInst cellViewId
                        masterCellViewId
                        nil
                        llX+indexX*SFQLayoutSymbolUnitLength:
                        llY+indexY*SFQLayoutSymbolUnitLength
                        "R0"
                        ))))
    else
    ; uless a moat cannot find in the cell libaray
    (printf "Error: Cannot find a moat cell in Lib: %s"
            (guessRefLib cellViewId )~>name )
    ))

;   returns the lower-left and upper-right coordinates of the instances
;   in the cellView.
(defun getCellViewbBoxADP (cellViewId SFQLayoutSymbolUnitLength ignoreLibs ignoreCells)
  ; do not consider cells in ignoreLibs or that matches to ignoreCells
  (define cellbBox nil)
  (define llx nil)
  (define lly nil)
  (define urx nil)
  (define ury nil)
  (define llxCell nil)
  (define llyCell nil)
  (define urxCell nil)
  (define uryCell nil)
  (define llxInst nil)
  (foreach
    inst cellViewId~>instances
    (unless
      (or (member inst~>libName ignoreLibs)
          ;(orList (mapcar (lambda (x) (rexMatchp x inst~>cellName ))
          ;                    ignoreCells)))
          (exists x ignoreCells
                  (rexMatchp x inst~>cellName)))
      (setq cellbBox (getCellbBoxADP inst SFQLayoutSymbolUnitLength))
      (setq llxCell  (xCoord (lowerLeft cellbBox)))
      (setq llyCell  (yCoord (lowerLeft cellbBox)))
      (setq urxCell  (xCoord (upperRight cellbBox)))
      (setq uryCell  (yCoord (upperRight cellbBox)))
      ; initial assignment
      (unless llx (setq llx llxCell))
      (unless lly (setq lly llyCell))
      (unless urx (setq urx urxCell))
      (unless ury (setq ury uryCell))
      (when (and llxCell llx llx>llxCell) (setq llx llxCell))
      (when (and llyCell lly lly>llyCell) (setq lly llyCell))
      (when (and urxCell urx urx<urxCell) (setq urx urxCell))
      (when (and uryCell ury ury<uryCell) (setq ury uryCell))
      ))
  (list llx:lly urx:ury))

; declare 2D array
(defun makeMoatArray (nX nY)
  (let ( xArray x )
    (declare xArray[ nX ] )
    (for i 0 nX-1
         declare( x[ nY ] )
         xArray[ i ] = x)
    xArray))

; getCellbBoxADP( inst )
; => ( llx:lly urx:ury ) in cellView
(defun getCellbBoxADP ( inst SFQLayoutSymbolUnitLength )
  (define cellSize (getCellSizeADP inst~>master))
  (define xy (plusCoord inst~>xy (offSetCoord cellSize inst~>orient)))
  (define llxCell (xCoord xy))
  (define llyCell (yCoord xy))
  (define urxCell (plus llxCell (xCoord cellSize)))
  (define uryCell (plus llyCell (yCoord cellSize)))
  (list llxCell:llyCell urxCell:uryCell))

(defun offSetCoord (size orient)
  ;;R0    , MXR90  ( 0, 0)
  ;;R90   , MY     (-x, 0)
  ;;R180  , MYR90  (-x,-y)
  ;;R270  , MX     ( 0,-y)
  (define mx (minus (xCoord size)))
  (define my (minus (yCoord size)))
  (cond
    ((or (equal orient "R0")
         (equal orient "MXR90"))
     (list 0 0))
    ((or (equal orient "R90")
         (equal orient "MY"))
     (list mx 0))
    ((or (equal orient "R180")
         (equal orient "MYR90"))
     (list mx my))
    ((or (equal orient "R270")
         (equal orient "MX"))
     (list 0 my))))

(defun getCellSizeADP (cellViewId)
  (define bBox nil)
  (define cell nil)
  (when (member cellViewId~>viewName '("symbol_p" "symbol_b"))
    (setq cell
          (car (exists x cellViewId~>shapes
                       (and (equal x~>layerName "instance")
                            (equal x~>purpose "drawing")
                            (equal x~>objType "rect")))))
    (when cell
      (setq bBox cell~>bBox)
      (list
        (xCoord (upperRight bBox)) - (xCoord (lowerLeft bBox))
        (yCoord (upperRight bBox)) - (yCoord (lowerLeft bBox))))))

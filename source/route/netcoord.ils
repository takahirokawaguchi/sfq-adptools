(defun getAllNetCoords (nets)
  (println nets)
  (mapcar (lambda (itpair)
            (mapcar getInstTermGridCoord itpair))
          nets~>instTerms))

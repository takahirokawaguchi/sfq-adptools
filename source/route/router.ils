(define rRoute nil)
(let ()
  ;(define scv nil)
  rRoute =
  (lambda (flagSelNet)
    (define scv (geGetWindowCellView ))
    ;routingnet.ils
    (define nets (selRoutingNets scv flagSelNet))
    (printf "number of routing net is %d.\n" (length nets))
    ;(printDebug "nets" 'nets nets)
    (define boundary (roGetBoundary (ruSBBtoGBB scv~>bBox)))
    ;(printDebug "boundary" 'boundary boundary)
    ;netCoord.ils
    (define netCoords (getAllNetCoords nets))
    ;(printDebug "netCoords" 'netCoords netCoords)
    ;blockage.ils
    ;(define blockages (getBlockage scv boundary))
    (define blockages nil)
    ;(printDebug "blockages" 'blockages blockages)
    (roWriteFile netCoords boundary blockages)
    ;(println "roWriteFile")
    (define res (riReadRouterOut ))
    ;(printDebug "riReadRouterOut" 'res res)
    (deleteNetFigs nets)
    ;(println "deleteNetFigs")
    (deleteNetConnectedPin scv)
    (rCreateWireAll scv "./in.riner" nets)
    (println "rCreateWireAll")
    )

  (defun deleteNetFigs (nets)
    (foreach
      net nets
      (foreach
        fig net~>figs
        (dbDeleteObject fig))))

  (defun deleteNetConnectedPin (scv)
   (foreach netCpin (setof x scv~>nets (andList x~>pins))
             (foreach fig netCpin~>figs
                      (dbDeleteObject fig))))

  (defun printDebug (str symb var)
    (println str)
    (println symbolToString(symb))
    (println (length var))
    (println var)
    )

  )

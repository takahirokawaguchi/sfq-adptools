;global functions
;declaration
(define mainTimingPropagation nil)

;defun
(defun findInstTermByName (cv nameInstAndInstTerm)
  (define inst nil)
  (if (car nameInstAndInstTerm)
    then
    (setq inst
          (dbFindAnyInstByName
            cv (car nameInstAndInstTerm)))
    (car (exists x
                 inst~>instTerms (equal x~>name (cadr nameInstAndInstTerm))))
    else
    nil))

(defun getNameInstAndInstTerm (instTerm)
  (list instTerm~>inst~>name instTerm~>name))

(defun getBiasVoltage (maxOrMin)
  (case
    (if (equal maxOrMin "max")
      (getOptionTimingAnalysis )->maxBiasVoltage->value
      (getOptionTimingAnalysis )->minBiasVoltage->value)
    ("-30%" 1)
    ("-25%" 2)
    ("-20%" 3)
    ("-15%" 4)
    ("-10%" 5)
    ("-5%"  6)
    ("0%"   7)
    ("+5%"  8)
    ("+10%" 9)
    ("+15%" 10)
    ("+20%" 11)
    ("+25%" 12)
    ("+30%" 13)))

(defun deleteAllArvTime (cv)
  (foreach
    x cv~>instances
    (foreach
      y x~>instTerms
      (dbDeletePropByName y "arvTimeMin")
      (dbDeletePropByName y "arvTimeMax")
      (dbDeletePropByName y "numPtlDrvMin")
      (dbDeletePropByName y "numPtlDrvMax")
      (dbDeletePropByName y "numNodes")
      (dbDeletePropByName y "namesPrecedingNodes")
      (dbDeletePropByName y "namesSuccedingNodes")
      (dbDeletePropByName y "numPtlCellMin")
      (dbDeletePropByName y "numPtlCellMax")
      )))

(defun deleteAllProp (cv)
  (foreach
    x cv~>instances
    (foreach prop x~>prop
             (dbDeletePropByName x prop~>name))
    (foreach
      y x~>instTerms
      (foreach prop y~>prop
               (dbDeletePropByName y prop~>name)))))

;local functions
;file scope
(let ()
  ;static variables
  (define DT nil);DelayTable
  (define cv nil);cellView
  (define TDT nil);timingDependencyTable
  (define netDelay "zero")
  (define netDelayCoeff 0.1597 / 0.1875)
  (define vbMax 8)
  (define vbMin 6)

  mainTimingPropagation =
  (lambda (argueCv)
    ;; initialization
    (printf "debug:maintimingpropagation\n")
    (setq cv argueCv)
    (when (boundp 'OPTION_TIMING_ANALYSIS)
      (setq netDelay (getOptionTimingAnalysis )->netDelay->value)
      (setq vbMax (getBiasVoltage "max"))
      (setq vbMin (getBiasVoltage "min"))
      )
    (printf "debug:deleteAllArvTime\n")
    (deleteAllArvTime cv)
    (setq DT (makeDelayTable cv))
    (setq TDT (makeTimingDependencyTable cv))
    ;start temrs
    (define time cputime())
    (printf "debug:define inputTermsCalcNext\n")
    (define inputTermsCalcNext (append (setIpins ) (setSources )))
    ;;procedure
    (printf "debug:setArvTimeInputTermsCalcNext\n")
    (setArvTimeInputTermsCalcNext inputTermsCalcNext)
    (printf "runtime of timing propagation is %.3f seconds\n"
            (quotient (difference (cputime ) time)
                  60.0)))

  ;local functions
  (defun setArvTimeInputTermsCalcNext (inputTermsCalcNext)
    (define inputTerm nil)
    (while
    (setq inputTerm (car inputTermsCalcNext))
      (printf "debug:%L\n" inputTerm~>inst~>name)
           (setq inputTermsCalcNext
                 (append
                   (cdr inputTermsCalcNext)
                   (constructGraph inputTerm)))))

  (defun setIpins ()
    (define ret nil)
    (define ipins (setof y cv~>instances (or (isIpin y) (isOpin y) (isIopin y))))
    (define y nil)
    (define inputTermConnectedX nil)
    (define inputTimeMap (getAndMakeInputTimeMap ))
    (foreach
      x ipins
      (when (and (setq y (assoc x~>net~>name inputTimeMap))
                 (setq inputTermConnectedX (car (inputTermsConnected x))))
        inputTermConnectedX~>arvTimeMin    = (cadr y)
        inputTermConnectedX~>arvTimeMax    = (caddr y)
        inputTermConnectedX~>numNodes      = 0
        inputTermConnectedX~>namesPrecedingNodes
        = (list (getNameInstAndInstTerm inputTermConnectedX))
        inputTermConnectedX~>numPtlCellMin = 0
        inputTermConnectedX~>numPtlCellMax = 0
        (setq ret (append1 ret inputTermConnectedX))))
    ret)

  (defun getAndMakeInputTimeMap ()
    (define fileName (sprintf nil "inputTimeMap_%s.txt" cv~>cellName))
    (define ifp (infile fileName))
    (define ofp nil)
    (define imap nil)
    (define temp nil)
    (if ifp
      then
      (setq imap nil)
      (while (setq temp (lineread ifp))
             (setq temp
                   (cons
                     (sprintf str "%s" (car temp))
                     (cdr temp)))
             (setq imap (cons temp imap)))
    (close ifp)
      else
      (setq ofp (outfile fileName "w"))
      (setq imap nil)
      (foreach x (setof y cv~>instances (or (isOpin y) (isIpin y) (isIopin y)))
               (fprintf ofp "%s %.1f %.1f\n" x~>net~>name 0.0 0.0)
               (setq imap (append1 imap (list x~>net~>name 0.0 0.0)))
               )
      (close ofp)
      )
    imap)

  (defun setSources ()
    (define ret
      (mapcar (lambda (x) (car (inputTermsConnected x)))
              (mapcar (lambda (x) (car (outputTerms x)))
                      (setof y cv~>instances (isSource y)))))
    (foreach
      x ret
      x~>arvTimeMin    = 10000.0
      x~>arvTimeMax    = -10000.0
      x~>numNodes      = 0
      x~>precedingNode = nil
      x~>numPtlCellMin = 0
      x~>numPtlCellMax = 0)
    ret)

  (defun constructGraph (inputTerm)
    (define ret nil)
    (define itcs nil)
    (define inputTermsTDT nil)
    (foreach
      outputTerm TDT->outputTermsDependTiming(inputTerm)
      (setq inputTermsTDT TDT->inputTermsDependTiming(outputTerm))
      (when (and (checkCalculability inputTermsTDT)
                 (null outputTerm~>arvTimeMin))
        (foreach
          it inputTermsTDT
          (setNode it outputTerm))
        ;ptl cell
        outputTerm~>numPtlCellMin = (minList inputTermsTDT~>numPtlCellMin)
        outputTerm~>numPtlCellMax = (maxList inputTermsTDT~>numPtlCellMax)
        (when (isPTL outputTerm~>inst)
          outputTerm~>numPtlCellMin = (plus 1 outputTerm~>numPtlCellMin)
          outputTerm~>numPtlCellMax = (plus 1 outputTerm~>numPtlCellMax))
        (setq itcs (inputTermsConnected outputTerm))
        (foreach itc itcs
                 (setNode outputTerm itc)
                 itc~>numPtlCellMin = outputTerm~>numPtlCellMin
                 itc~>numPtlCellMax = outputTerm~>numPtlCellMax)
        (setArvTime outputTerm itcs)
        (setq ret (append ret itcs))
        ))
    ret)

  (defun isCalculated (instTerm)
    (and instTerm~>arvTimeMin instTerm~>arvTimeMax))

  (defun checkCalculability (inputTermsTDT)
    (forall x inputTermsTDT (isCalculated x)))

  (defun setNode (precedingTerm succedingTerm)
    (define namePrecedingNode nil)
    (define precedingNode nil)
    (define numNodes nil)
    (if (TDT->isNode precedingTerm)
      (setq namePrecedingNode (getNameInstAndInstTerm precedingTerm))
      (setq namePrecedingNode (car precedingTerm~>namesPrecedingNodes)))
    (if TDT->isNode(succedingTerm)
      then; succedingTerm is a node
      (setq precedingNode (findInstTermByName cv namePrecedingNode))
      succedingTerm~>namesPrecedingNodes
      = (append1 succedingTerm~>namesPrecedingNodes namePrecedingNode)
      (setq numNodes (plus 1 precedingNode~>numNodes))
      (if succedingTerm~>numNodes
        succedingTerm~>numNodes = (max succedingTerm~>numNodes numNodes)
        succedingTerm~>numNodes = numNodes)
      precedingNode~>namesSuccedingNodes
      = (append1 precedingNode~>namesSuccedingNodes
                 (getNameInstAndInstTerm succedingTerm))
      else; succedingTerm is not a node
      succedingTerm~>namesPrecedingNodes = (list namePrecedingNode)
      ))

  (defun setArvTime (outputTerm connectedInputTerms)
    (define inputTerms TDT->inputTermsDependTiming(outputTerm))
    outputTerm~>arvTimeMin
    = (minList (mapcar (lambda (x) (calcArvTimeDiffMin x~>arvTimeMin x outputTerm))
                       inputTerms))
    outputTerm~>arvTimeMax
    = (maxList (mapcar (lambda (x) (calcArvTimeDiffMax x~>arvTimeMax x outputTerm))
                       inputTerms))
    (foreach
      connectedInputTerm connectedInputTerms
      connectedInputTerm~>arvTimeMin =
      (plus
        outputTerm~>arvTimeMin
        (getNetDelay outputTerm connectedInputTerm))
      connectedInputTerm~>arvTimeMax =
      (plus
        outputTerm~>arvTimeMax
        (getNetDelay outputTerm connectedInputTerm))
      ))

  (defun getNetDelay (outputTerm inputTerm)
    (define ret 0.0)
    (define net inputTerm~>net)
    (cond
      ((equal netDelay "manhattan")
       (setq ret
             (plus (abs (difference (xCoord (getInstTermCoord outputTerm))
                                    (xCoord (getInstTermCoord inputTerm))))
                   (abs (difference (yCoord (getInstTermCoord outputTerm))
                                    (yCoord (getInstTermCoord inputTerm))))))
       (setq ret
             (times netDelayCoeff ret)))
      ((and
         (equal netDelay "net_length")
         net~>figs)
       (foreach
         x net~>figs
         (setq ret
               ret
               + (abs (difference (caar x~>points) (caadr x~>points)))
               + (abs (difference (cadar x~>points) (cadadr x~>points)))))
       (setq ret
             (times netDelayCoeff ret)))
      ((equal netDelay "net_length_layout")
         (setq ret .0))
      (t
         (setq ret .0))
      )
    ret)

  (defun calcArvTimeDiffMax (arvTime inputTerm outputTerm)
    (plus arvTime
          DT->getDelay(inputTerm outputTerm vbMin)))

  (defun calcArvTimeDiffMin (arvTime inputTerm outputTerm)
    (plus arvTime
          DT->getDelay(inputTerm outputTerm vbMax)))

  );let

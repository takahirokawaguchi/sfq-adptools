(defun datGui ()
  (define time nil)
  (define scv (geGetWindowCellView ))
  (unless (boundp 'OPTION_TIMING_ANALYSIS)
    (createOptionTimingAnalysis scv))
  (define
    ok (hiDisplayForm 'OPTION_TIMING_ANALYSIS))
  (printf "%L" (getOptionTimingAnalysis )->removeLabels->value)
  (when ok
    (setq time cputime);cputime is a system function
    (displayArrivalTime scv)
    (printf "runtime is %.3f seconds\n"
            (quotient
              (difference cputime time)
              60.0))
    ))

(defun displayArrivalTime (scv)
  ;(define paramList (getParamsFromOptionsForm ))
  (removeAllLabels scv)
  (unless (nequal (getOptionTimingAnalysis )->removeLabels->value
                  "off")
    (mainTimingPropagation scv)
    (glueLabelsToInst_inout scv)
    )
  (when (nequal (getOptionTimingAnalysis )->staField->value
                "off")
    (calculateSlacks scv)))

;(defun writeArrivalTime (scv @key (paramList nil))
;  (unless (cadddr (cdddr paramList))
;    (calcArvTimeAll
;      scv
;      ?vb (caddr paramList)
;      ?inputTimeMap (car paramList)
;      ?netDelayCoeff (cadr paramList))
;    ))

;(defun getParamsFromOptionsForm ()
;  (define result nil)
;  (define out nil)
;  (define temp nil)
;  (define imap nil)
;  (define scv (geGetWindowCellView ))
;  (define fileName (sprintf nil "inputTimeMap_%s.txt" scv~>cellName))
;  (define in (infile fileName))
;  (if in
;    (progn;then
;      (setq imap nil)
;      (while (setq temp (lineread in))
;             (setq temp
;                   (cons
;                     (sprintf nil "%s" (car temp))
;                     (cdr temp)))
;             (setq imap (cons temp imap)))
;      (setq result (list imap)))
;    (progn;else
;      (setq out (outfile fileName "w"))
;      (setq imap nil)
;      (foreach x (setof y scv~>instances (or (isOpin y) (isIpin y) (isIopin y)))
;               (fprintf out "%s %.1f %.1f\n" x~>net~>name 0.0 0.0)
;               (setq imap (append1 imap (list x~>net~>name 0.0 0.0)))
;               )
;      (close out)
;      (setq result (list imap))
;      ))
;  (if
;    (member (getOptionTimingAnalysis )->netDelay->value
;            '("PTLdelay" "PTLdelay_only" "PTLdelay_only_ideal" "PTLdelay_ideal"))
;    (setq result (append1 result (getOptionTimingAnalysis )->netDelay~>value))
;    (setq result (append1 result (evalstring (getOptionTimingAnalysis )->netDelay~>value))))
;  (let (vb)
;    (setq vb (case (getOptionTimingAnalysis )->biasVoltage~>value
;               ("-30%" 1)
;               ("-25%" 2)
;               ("-20%" 3)
;               ("-15%" 4)
;               ("-10%" 5)
;               ("-5%"  6)
;               ("0%"   7)
;               ("+5%"  8)
;               ("+10%" 9)
;               ("+15%" 10)
;               ("+20%" 11)
;               ("+25%" 12)
;               ("+30%" 13)))
;    (setq result (append1 result vb)))
;  (setq result (append1 result (getOptionTimingAnalysis )->staField~>value))
;  (setq result (append1 result
;                        (getOptionTimingAnalysis )->staTypeField~>value
;                        ))
;  (setq result (append1 result
;                        (getOptionTimingAnalysis )->staFilteringField~>value))
;  (if (equal (getOptionTimingAnalysis )->isRemoveField~>value "off")
;    (setq result (append1 result nil))
;    (setq result (append1 result t)))
;  result)
;
;(defun glueLabelsToInst (scv)
;  (foreach
;    inst scv~>instances
;    (foreach
;      x (outputTerms inst)
;      (when
;        (and
;          x~>arvTimeMin
;          (or
;            (null (isPTLFamily inst))
;            (isPTLRec inst)))
;        (glueLabelsToInstTerm x (list x~>arvTimeMin x~>numPtlCellMin x~>numSpl) "upperCenter")
;        (glueLabelsToInstTerm x (list x~>arvTimeMax x~>numPtlCellMax x~>numSpl) "lowerCenter")))
;    ))

(defun glueLabelsToInst_inout (scv)
  (foreach
    inst scv~>instances
    (foreach
      x (outputTerms inst)
      (when (and x~>arvTimeMin
                 (or
                   (null (isPTLFamily inst))
                   (isPTLRec inst)))
        (glueLabelsToInstTerm x (list x~>arvTimeMin x~>numPtlCellMin) "upperCenter")
        (glueLabelsToInstTerm x (list x~>arvTimeMax x~>numPtlCellMax) "lowerCenter")))
    (foreach x (inputTerms inst)
             (when
               (and x~>arvTimeMin
                    (or (null (isPTLFamily inst)) (isPTLRec inst)))
               (glueLabelsToInstTerm x (list x~>arvTimeMin x~>numPtlCellMin) "upperCenter")
               (glueLabelsToInstTerm x (list x~>arvTimeMax x~>numPtlCellMax) "lowerCenter")))
    ))

(defun glueLabelsToInstTerm (instTerm arvTime position)
  (define label
    (dbCreateLabel
      instTerm~>inst~>cellView
      DISPLAY_ARRIVAL_TIME_CONST.LABEL_LAYER
      (getInstTermCoord instTerm)
      (sprintf nil "%.1f\n%d" (car arvTime) (cadr arvTime))
      position
      "R0"
      "roman"
      0.03125))
  (schGlueLabel label instTerm~>inst)
  label~>instTermName = instTerm~>name)

(defun getInstTermCoord (instTerm)
  (define masterTerm nil)
  (define masterTermXY nil)
  (cond
    ((nequal instTerm~>objType "instTerm")
     (warn "calcInstTermCoord: object \"%L\" not instTerm." instTerm))
    ((null
       (and
         (setq masterTerm
               (car (exists x instTerm~>inst~>master~>terminals
                            (equal x~>name instTerm~>name))))
         (setq masterTermXY (centerBox (car masterTerm~>pins)~>fig~>bBox))))
     (warn "calcInstTermCoord: cannot get pin \"%s\" coordinate." instTerm~>name))
    (t
      (dbTransformPoint
        masterTermXY
        (list instTerm~>inst~>xy
              instTerm~>inst~>orient)))))

(defun upperCenter (bBox)
  (list ((caar bBox) + (caadr bBox)) / 2
        (cadadr bBox)))

(defun removeAllLabels (scv)
  (foreach
    instance scv~>instances
    (foreach
      child instance~>children
      (when
        (and
          (equal child~>objType "label")
          child~>instTermName)
        (dbDeleteObject child))))
  (deleteAllArvTime scv))
